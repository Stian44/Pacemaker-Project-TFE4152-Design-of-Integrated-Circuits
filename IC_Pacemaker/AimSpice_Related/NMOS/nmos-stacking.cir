[aimspice]
[description]
304
NOR Gate stacking
.include p18_cmos_models_tt.inc

MP1 n1 A VDD VDD PMOS L=0.5U W=10U
MP2 OUT B n1 VDD PMOS L=0.5U W=10U

MN1 OUT A n2 0 NMOS L=0.5U W=10U
MN2 n2 A 0 0 NMOS L=0.5U W=10U

MN3 OUT B n3 0 NMOS L=0.5U W=10U
MN4 OUT B 0 0 NMOS L=0.5U W=10U

VDD VDD 0 1.8
V_A A 0 1
V_B B 0 1

[options]
0
[end]
