[aimspice]
[description]
704
Inverter Simulation
.include p18_cmos_models_tt.inc

.param L_value=0.36U
.param W_value=0.18U

*Inverter
*MP1 OUT A VDD VDD PMOS L={L_value} W={W_value}

*MN1 OUT A  0   0  NMOS L={L_value} W={W_value}

*--------

*Inverter NMOS stacked
*MP1 OUT A VDD VDD PMOS L={L_value} W={W_value}

*MN1 OUT A  TS  0  NMOS L={L_value} W={W_value}
*MN2 TS  A  0   0  NMOS L={L_value} W={W_value}

*--------

*Inverter Double Stacked
MP1 TSP A VDD VDD PMOS L={L_value} W={W_value}
MP2 OUT A TSP VDD PMOS L={L_value} W={W_value}

MN1 OUT A TSN  0  NMOS L={L_value} W={W_value}
MN2 TSN A  0   0  NMOS L={L_value} W={W_value}

*--------

*Voltage sources
VDD VDD 0 1.8
V_A  A  0 0

[options]
0
[dc]
1
V_A
0
0.1
0.01
[ana]
1 1
0
1 1
1 1 0 0.1
1
v(out)
[end]
