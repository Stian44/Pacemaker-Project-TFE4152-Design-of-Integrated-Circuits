[aimspice]
[description]
2223
FSM next-state logic - minimum VDD
.include p18_cmos_models_ss.inc

VDD vdd 0 0.55

* Worst-case logic levels that follow VDD
EHI hi 0 vdd 0 0.75
ELO lo 0 vdd 0 0.25

* Reference lines for the limits
E75 ref75 0 vdd 0 0.75
E25 ref25 0 vdd 0 0.25

* ---------------- Gates (W = 0.18U, L = 0.36U) ----------------
* NAND2: input a drives the upper NMOS (next to the output)
.subckt nand2 y a b vdd
MPA y a vdd vdd PMOS W=0.18U L=0.36U
MPB y b vdd vdd PMOS W=0.18U L=0.36U
MNA y a m 0 NMOS W=0.18U L=0.36U
MNB m b 0 0 NMOS W=0.18U L=0.36U
.ends

* NOR2: input a drives the upper PMOS (next to VDD)
.subckt nor2 y a b vdd
MPA m a vdd vdd PMOS W=0.18U L=0.36U
MPB y b m vdd PMOS W=0.18U L=0.36U
MNA y a 0 0 NMOS W=0.18U L=0.36U
MNB y b 0 0 NMOS W=0.18U L=0.36U
.ends

.subckt inv y a vdd
MP y a vdd vdd PMOS W=0.18U L=0.36U
MN y a 0 0 NMOS W=0.18U L=0.36U
.ends

* ---------------- Next-state logic ----------------
* G1 = ~(BT)
* G2: A+ = ~(H + ~(BT))
* G3 = ~(A + H)
* G4 = ~(~(BT) . ~(A + H))
* INV: B+ = ~G4
.subckt logic a b t h ap bp vdd
XG1 nbt b t vdd nand2
XG2 ap h nbt vdd nor2
XG3 anh a h vdd nor2
XG4 g4 nbt anh vdd nand2
XN1 bp g4 vdd inv
.ends

* ---------------- All 16 input combinations ----------------
* Naming: apABTH / bpABTH
* Expected:  0000: A+=0 B+=1   0001: A+=0 B+=0   0010: A+=0 B+=1   0011: A+=0 B+=0
*            0100: A+=0 B+=1   0101: A+=0 B+=0   0110: A+=1 B+=0   0111: A+=0 B+=0
*            1000 to 1101: A+=0 B+=0   1110: A+=1 B+=0   1111: A+=0 B+=0
X0000 lo lo lo lo ap0000 bp0000 vdd logic
X0001 lo lo lo hi ap0001 bp0001 vdd logic
X0010 lo lo hi lo ap0010 bp0010 vdd logic
X0011 lo lo hi hi ap0011 bp0011 vdd logic
X0100 lo hi lo lo ap0100 bp0100 vdd logic
X0101 lo hi lo hi ap0101 bp0101 vdd logic
X0110 lo hi hi lo ap0110 bp0110 vdd logic
X0111 lo hi hi hi ap0111 bp0111 vdd logic
X1000 hi lo lo lo ap1000 bp1000 vdd logic
X1001 hi lo lo hi ap1001 bp1001 vdd logic
X1010 hi lo hi lo ap1010 bp1010 vdd logic
X1011 hi lo hi hi ap1011 bp1011 vdd logic
X1100 hi hi lo lo ap1100 bp1100 vdd logic
X1101 hi hi lo hi ap1101 bp1101 vdd logic
X1110 hi hi hi lo ap1110 bp1110 vdd logic
X1111 hi hi hi hi ap1111 bp1111 vdd logic

[dc]
1
VDD
0.05
0.8
0.01
[ana]
1 3
0
1 1
1 1 -3.46945E-17 0.8
17
v(ref25)
v(bp0000)
v(bp0001)
v(bp0010)
v(bp0011)
v(bp0100)
v(bp0101)
v(bp0110)
v(bp0111)
v(bp1000)
v(bp1001)
v(bp1010)
v(bp1011)
v(bp1100)
v(bp1101)
v(bp1110)
v(bp1111)
0
1 1
1 1 0 0.8
17
v(ref25)
v(ap0000)
v(ap0001)
v(ap0010)
v(ap0011)
v(ap0100)
v(ap0101)
v(ap0110)
v(ap0111)
v(ap1000)
v(ap1001)
v(ap1010)
v(ap1011)
v(ap1100)
v(ap1101)
v(ap1110)
v(ap1111)
0
1 1
1 1 0 5
5
v(ref75)
v(bp0010)
v(bp0100)
v(ap0110)
v(ap1110)
[end]
